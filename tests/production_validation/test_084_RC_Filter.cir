* RC Low-Pass Filter — production validation goldens
V1 in 0 DC 0 SIN(0 1 184 0 0 0)
R1 in out 84000
C1 out 0 1e-09
.tran 2.71739e-06 0.00543478 uic
.end
