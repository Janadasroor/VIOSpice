* RC Low-Pass Filter — production validation goldens
V1 in 0 DC 0 SIN(0 1 136 0 0 0)
R1 in out 36000
C1 out 0 1e-09
.tran 3.67647e-06 0.00735294 uic
.end
