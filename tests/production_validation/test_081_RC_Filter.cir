* RC Low-Pass Filter — production validation goldens
V1 in 0 DC 0 SIN(0 1 181 0 0 0)
R1 in out 81000
C1 out 0 1e-09
.tran 2.76243e-06 0.00552486 uic
.end
