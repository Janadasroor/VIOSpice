* RC Low-Pass Filter — production validation goldens
V1 in 0 DC 0 SIN(0 1 150 0 0 0)
R1 in out 50000
C1 out 0 1e-09
.tran 3.33333e-06 0.00666667 uic
.end
