* Diode Clipper — production validation goldens
V1 in 0 DC 0 SIN(0 2.25 205 0 0 0)
D1 in out CLIP
R1 out 0 1k
.model CLIP D(IS=1e-14 N=1.8)
.tran 2.43902e-06 0.00487805 uic
.end
