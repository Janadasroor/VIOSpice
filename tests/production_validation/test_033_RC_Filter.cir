* RC Low-Pass Filter — production validation goldens
V1 in 0 DC 0 SIN(0 1 133 0 0 0)
R1 in out 33000
C1 out 0 1e-09
.tran 3.7594e-06 0.0075188 uic
.end
