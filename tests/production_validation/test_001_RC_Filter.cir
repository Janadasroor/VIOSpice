* RC Low-Pass Filter — production validation goldens
V1 in 0 DC 0 SIN(0 1 101 0 0 0)
R1 in out 1000
C1 out 0 1e-09
.tran 4.9505e-06 0.00990099 uic
.end
