* RC Low-Pass Filter — production validation goldens
V1 in 0 DC 0 SIN(0 1 170 0 0 0)
R1 in out 70000
C1 out 0 1e-09
.tran 2.94118e-06 0.00588235 uic
.end
