* OpAmp Inverting Gain Stage — production validation goldens
V1 in 0 DC 0 SIN(0 0.1 338 0 0 0)
R1 in n1 1000
R2 n1 out 39000
E1 out 0 n1 0 100000
.tran 1.47929e-06 0.00295858 uic
.end
