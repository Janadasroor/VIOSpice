* RC Low-Pass Filter — production validation goldens
V1 in 0 DC 0 SIN(0 1 149 0 0 0)
R1 in out 49000
C1 out 0 1e-09
.tran 3.3557e-06 0.00671141 uic
.end
