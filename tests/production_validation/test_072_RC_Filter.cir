* RC Low-Pass Filter — production validation goldens
V1 in 0 DC 0 SIN(0 1 172 0 0 0)
R1 in out 72000
C1 out 0 1e-09
.tran 2.90698e-06 0.00581395 uic
.end
