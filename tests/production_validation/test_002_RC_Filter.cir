* RC Low-Pass Filter — production validation goldens
V1 in 0 DC 0 SIN(0 1 102 0 0 0)
R1 in out 2000
C1 out 0 1e-09
.tran 4.90196e-06 0.00980392 uic
.end
