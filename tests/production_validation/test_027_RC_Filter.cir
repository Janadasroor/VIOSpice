* RC Low-Pass Filter — production validation goldens
V1 in 0 DC 0 SIN(0 1 127 0 0 0)
R1 in out 27000
C1 out 0 1e-09
.tran 3.93701e-06 0.00787402 uic
.end
