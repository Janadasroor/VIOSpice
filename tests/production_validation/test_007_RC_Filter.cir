* RC Low-Pass Filter — production validation goldens
V1 in 0 DC 0 SIN(0 1 107 0 0 0)
R1 in out 7000
C1 out 0 1e-09
.tran 4.6729e-06 0.00934579 uic
.end
