* RC Low-Pass Filter — production validation goldens
V1 in 0 DC 0 SIN(0 1 114 0 0 0)
R1 in out 14000
C1 out 0 1e-09
.tran 4.38596e-06 0.00877193 uic
.end
