* RC Low-Pass Filter — production validation goldens
V1 in 0 DC 0 SIN(0 1 151 0 0 0)
R1 in out 51000
C1 out 0 1e-09
.tran 3.31126e-06 0.00662252 uic
.end
