* RC Low-Pass Filter — production validation goldens
V1 in 0 DC 0 SIN(0 1 157 0 0 0)
R1 in out 57000
C1 out 0 1e-09
.tran 3.18471e-06 0.00636943 uic
.end
