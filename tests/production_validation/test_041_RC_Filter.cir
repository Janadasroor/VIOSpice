* RC Low-Pass Filter — production validation goldens
V1 in 0 DC 0 SIN(0 1 141 0 0 0)
R1 in out 41000
C1 out 0 1e-09
.tran 3.5461e-06 0.0070922 uic
.end
