* RC Low-Pass Filter — production validation goldens
V1 in 0 DC 0 SIN(0 1 104 0 0 0)
R1 in out 4000
C1 out 0 1e-09
.tran 4.80769e-06 0.00961538 uic
.end
