* RC Low-Pass Filter — production validation goldens
V1 in 0 DC 0 SIN(0 1 118 0 0 0)
R1 in out 18000
C1 out 0 1e-09
.tran 4.23729e-06 0.00847458 uic
.end
