* RC Low-Pass Filter — production validation goldens
V1 in 0 DC 0 SIN(0 1 115 0 0 0)
R1 in out 15000
C1 out 0 1e-09
.tran 4.34783e-06 0.00869565 uic
.end
