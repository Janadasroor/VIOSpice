* RC Low-Pass Filter — production validation goldens
V1 in 0 DC 0 SIN(0 1 158 0 0 0)
R1 in out 58000
C1 out 0 1e-09
.tran 3.16456e-06 0.00632911 uic
.end
