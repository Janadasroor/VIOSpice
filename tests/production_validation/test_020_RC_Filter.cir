* RC Low-Pass Filter — production validation goldens
V1 in 0 DC 0 SIN(0 1 120 0 0 0)
R1 in out 20000
C1 out 0 1e-09
.tran 4.16667e-06 0.00833333 uic
.end
