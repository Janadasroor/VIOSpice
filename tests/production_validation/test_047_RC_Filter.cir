* RC Low-Pass Filter — production validation goldens
V1 in 0 DC 0 SIN(0 1 147 0 0 0)
R1 in out 47000
C1 out 0 1e-09
.tran 3.40136e-06 0.00680272 uic
.end
