* RC Low-Pass Filter — production validation goldens
V1 in 0 DC 0 SIN(0 1 166 0 0 0)
R1 in out 66000
C1 out 0 1e-09
.tran 3.01205e-06 0.0060241 uic
.end
