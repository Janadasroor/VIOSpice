* RC Low-Pass Filter — production validation goldens
V1 in 0 DC 0 SIN(0 1 173 0 0 0)
R1 in out 73000
C1 out 0 1e-09
.tran 2.89017e-06 0.00578035 uic
.end
