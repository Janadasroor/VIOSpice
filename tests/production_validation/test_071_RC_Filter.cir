* RC Low-Pass Filter — production validation goldens
V1 in 0 DC 0 SIN(0 1 171 0 0 0)
R1 in out 71000
C1 out 0 1e-09
.tran 2.92398e-06 0.00584795 uic
.end
